# Ansys Electronics Desktop project, version 2022.2
materials:
  Cogent Power - M270-35A, B-H at 50Hz: core_loss_curve{50Hz (0, 0) (0.05, 0.015) (0.1, 0.03) (0.15, 0.05) (0.2, 0.07) (0.25, 0.1) (0.3, 0.13) (0.35, 0.175) (0.4, 0.22) (0.45, 0.265) (0.5, 0.31) (0.55, 0.37) (0.6, 0.43) (0.65, 0.485) (0.7, 0.54) (0.75, 0.61) (0.8, 0.68) (0.85, 0.755) (0.9, 0.83) (0.95, 0.92) (1, 1.01) (1.05, 1.105) (1.1, 1.2) (1.15, 1.31) (1.2, 1.42) (1.25, 1.56) (1.3, 1.7) (1.35, 1.91) (1.4, 2.12) (1.45, 2.295) (1.5, 2.47) (1.55, 2.635) (1.6, 2.8) (1.65, 2.925) (1.7, 3.05) (1.75, 3.15) (1.8, 3.25)} core_loss_curve{100Hz (0, 0) (0.05, 0.02) (0.1, 0.04) (0.15, 0.1) (0.2, 0.16) (0.25, 0.25) (0.3, 0.34) (0.35, 0.445) (0.4, 0.55) (0.45, 0.675) (0.5, 0.8) (0.55, 0.93) (0.6, 1.06) (0.65, 1.22) (0.7, 1.38) (0.75, 1.555) (0.8, 1.73) (0.85, 1.915) (0.9, 2.1) (0.95, 2.305) (1, 2.51) (1.05, 2.745) (1.1, 2.98) (1.15, 3.245) (1.2, 3.51) (1.25, 3.83) (1.3, 4.15) (1.35, 4.56) (1.4, 4.97) (1.45, 5.445) (1.5, 5.92) (1.55, 6.395) (1.6, 6.87) (1.65, 7.345) (1.7, 7.82) (1.75, 8.295) (1.8, 8.77)} core_loss_curve{200Hz (0, 0) (0.05, 0.045) (0.1, 0.09) (0.15, 0.23) (0.2, 0.37) (0.25, 0.58) (0.3, 0.79) (0.35, 1.05) (0.4, 1.31) (0.45, 1.61) (0.5, 1.91) (0.55, 2.26) (0.6, 2.61) (0.65, 3) (0.7, 3.39) (0.75, 3.825) (0.8, 4.26) (0.85, 4.745) (0.9, 5.23) (0.95, 5.765) (1, 6.3) (1.05, 6.905) (1.1, 7.51) (1.15, 8.195) (1.2, 8.88) (1.25, 9.69) (1.3, 10.5) (1.35, 11.5) (1.4, 12.5) (1.45, 13.7) (1.5, 14.9) (1.55, 16.1) (1.6, 17.3) (1.65, 18.5) (1.7, 19.7) (1.75, 20.9) (1.8, 22.1)} core_loss_curve{400Hz (0, 0) (0.05, 0.105) (0.1, 0.21) (0.15, 0.565) (0.2, 0.92) (0.25, 1.455) (0.3, 1.99) (0.35, 2.66) (0.4, 3.33) (0.45, 4.135) (0.5, 4.94) (0.55, 5.89) (0.6, 6.84) (0.65, 7.92) (0.7, 9) (0.75, 10.2) (0.8, 11.4) (0.85, 12.8) (0.9, 14.2) (0.95, 15.75) (1, 17.3) (1.05, 19.1) (1.1, 20.9) (1.15, 22.9) (1.2, 24.9) (1.25, 27.2) (1.3, 29.5) (1.35, 32.45) (1.4, 35.4) (1.45, 38.6) (1.5, 41.8) (1.55, 45) (1.6, 48.2) (1.65, 51.4) (1.7, 54.6) (1.75, 57.8) (1.8, 61)} core_loss_curve{1000Hz (0, 0) (0.05, 0.495) (0.1, 0.99) (0.15, 2.33) (0.2, 3.67) (0.25, 5.65) (0.3, 7.63) (0.35, 10.165) (0.4, 12.7) (0.45, 15.8) (0.5, 18.9) (0.55, 22.65) (0.6, 26.4) (0.65, 30.9) (0.7, 35.4) (0.75, 40.7) (0.8, 46) (0.85, 52.2) (0.9, 58.4) (0.95, 65.7) (1, 73) (1.05, 81.55) (1.1, 90.1) (1.15, 98.65) (1.2, 107.2) (1.25, 115.75) (1.3, 124.3) (1.35, 132.85) (1.4, 141.4) (1.45, 149.95) (1.5, 158.5) (1.55, 167.05) (1.6, 175.6) (1.65, 184.15) (1.7, 192.7) (1.75, 201.25) (1.8, 209.8)} permeability{HUnit=A_per_meter BUnit=tesla curve (0, 0) (5, 0.0087962) (10.5, 0.0194899) (20, 0.0477508) (30, 0.1) (39.6, 0.2) (46, 0.3) (52, 0.4) (58.2, 0.5) (65.2, 0.6) (73.3, 0.7) (83.1, 0.8) (95.5, 0.9) (112, 1) (136, 1.1) (178, 1.2) (272, 1.3) (596, 1.4) (1700, 1.5) (3880, 1.6) (7160, 1.7) (11600, 1.8) (20000, 1.89456) (50000, 2.06109) (100000, 2.18706) (140000, 2.24821) (150000, 2.26074)} conductivity=1923080 core_loss_type="Electrical Steel" core_loss_kh=156.32 core_loss_kc=0.211218 core_loss_ke=6.2369 mass_density=7650
  copper: permeability=0.999991 conductivity=58000000 mass_density=8933
  Magnet_project2: permeability=1.05 conductivity=877193 magnetic_coercivity{Magnitude=-985244.89A_per_meter DirComp1=1 DirComp2=0 DirComp3=0} mass_density=7300
  vacuum: permittivity=1
  Cogent_2DSF0.950: permeability{HUnit=A_per_meter BUnit=tesla curve (0, 0) (5, 0.0083567) (10.5, 0.0185161) (20, 0.0453645) (30, 0.0950019) (39.6, 0.190002) (46, 0.285003) (52, 0.380003) (58.2, 0.475004) (65.2, 0.570004) (73.3, 0.665005) (83.1, 0.760005) (95.5, 0.855006) (112, 0.950007) (136, 1.04501) (178, 1.14001) (272, 1.23502) (596, 1.33004) (1700, 1.42511) (3880, 1.52024) (7160, 1.61545) (11600, 1.71073) (20000, 1.80109) (50000, 1.96118) (100000, 2.08399) (140000, 2.1446) (150000, 2.15713) (250000, 2.28245)} conductivity=1923080 core_loss_type="Electrical Steel" core_loss_kh=164.547 core_loss_kc=0.222335 core_loss_ke=6.39892 mass_density=7267.5
  Magnet_project2_2DSF1.000_N: CoordinateSystemType=Cylindrical permeability=1.05 conductivity=877193 magnetic_coercivity{Magnitude=-985245A_per_meter DirComp1=1 DirComp2=0 DirComp3=0} mass_density=7300
  Magnet_project2_2DSF1.000_S: CoordinateSystemType=Cylindrical permeability=1.05 conductivity=877193 magnetic_coercivity{Magnitude=-985245A_per_meter DirComp1=-1 DirComp2=0 DirComp3=0} mass_density=7300

design RMxprtDesign2 (RMxprt, Brushless Permanent-Magnet DC Motor, model units mm)
machine:
  Machine: FrictionLoss=0W WindLoss=0W ReferenceSpeed=1500rpm NumberOfPoles=14 RotorPosition=true ControlType=0 CircuitType=Y3
  Circuit: TriggerPulseWidth=120deg TransistorDrop=0V DiodeDrop=0V LeadAngleOfTrigger=0deg MaximumCurrent=0A MinimumCurrent=0A
  Stator: SkewWidth=0 NumberOfSlots=15 LaminationSectors=0 PressBoardThickness=0mm OuterDiameter=100mm InnerDiameter=64mm Length=100mm StackingFactor=0.95 SteelType="Cogent Power - M270-35A, B-H at 50Hz" SlotType=3
  Rotor: OuterDiameter=62mm InnerDiameter=32mm Length=100mm SteelType="Cogent Power - M270-35A, B-H at 50Hz" PoleType=1 StackingFactor=0.95
  Shaft:
  Stator Slot: Hs0=1mm Hs1=0mm Hs2=9.67mm Bs0=1mm Bs1=5.09mm Bs2=6.79mm Rs=0mm ParallelTooth ToothWidth=8.31mm
  Stator Winding: WindingType=Editor WindingLayers=2 ParallelBranches=1 ConductorsPerSlot=12 CoilPitch=1 EndAdjustment=0mm BaseInnerRadius=0mm TipInnerDiameter=0mm EndClearance=0mm CoilWrap=0mm SlotLiner=0mm WedgeThickness=0mm LayerInsulation=0mm BottomInsulation=0mm LimitedFillFactor=0.75 WdgNumberofPriodicMultipler=1 WdgConstantTurns Wdgcoil_turns(6, 6, 6, 6, 6, 6, 6, 6, 6, 6, 6, 6, 6, 6, 6) Wdgcoil_name(A, -A, A, B, -B, B, -B, B, C, -C, C, -C, C, A, -A) Wdgcoil_go(1T, 2T, 3T, 4T, 5T, 6T, 7T, 8T, 9T, 10T, 11T, 12T, 13T, 14T, 15T) Wdgcoil_re(15B, 1B, 2B, 3B, 4B, 5B, 6B, 7B, 8B, 9B, 10B, 11B, 12B, 13B, 14B) NumberOfStrands=0 WireWrap=0mm InterturnInsulation=0mm WireDiameter=1.86mm WireWidth=0mm WireThickness=0mm Gauge=0
  Rotor Pole: Embrace=0.889 Offset=0mm ShaftDiameter=0mm Bridge=0mm Rib=0mm MagnetThickness=4mm MagnetWidth=0mm MagnetType=Magnet_project2
setups:
  Setup1: BLDC Motor RatedOutputPower=831W RatedVoltage=48V RatedSpeed=1500rpm OperatingTemperature=50cel LoadType=ConstSpeed
reports:
  Coil Voltage Plot 1: OneTurnVoltage vs ElectricalDegree on Setup1 : Performance
  Current Plot 1: PhaseCurrent1a vs ElectricalDegree on Setup1 : Performance
  Current Plot 2: SourceCurrent vs ElectricalDegree on Setup1 : Performance
  Induced Voltage Plot 1: InducedPhaseVoltage vs ElectricalDegree on Setup1 : Performance
  Flux Density Plot 1: AirGapFluxDensity vs ElectricalDegree on Setup1 : Performance
  Torque Plot 1: CoggingTorque vs ElectricalDegree on Setup1 : Performance

design Maxwell2DDesign1 (Maxwell 2D, Transient, XY geometry, model units mm)
options: ComputeTransientInductance ModelDepth=100mm
variables:
  fractions = 1
  I = 0A
geometry:
  Band [vacuum] = user_primitive(RMxprt/Band, DiaGap=63mm, DiaYoke=32mm, Length=0mm, SegAngle=0deg, Fractions=1, HalfAxial=0, InfoCore=0)
  Shaft [vacuum] = user_primitive(RMxprt/Band, DiaGap=63mm, DiaYoke=32mm, Length=0mm, SegAngle=0deg, Fractions=1, HalfAxial=0, InfoCore=100)
  OuterRegion [vacuum] = user_primitive(RMxprt/Band, DiaGap=63mm, DiaYoke=100mm, Length=0mm, SegAngle=0deg, Fractions=fractions, HalfAxial=0, InfoCore=100)
  Tool = user_primitive(RMxprt/Band, DiaGap=63mm, DiaYoke=100mm, Length=0mm, SegAngle=0deg, Fractions=fractions, HalfAxial=0, InfoCore=1)
  Stator [Cogent_2DSF0.950] = user_primitive(RMxprt/SlotCore, DiaGap=64mm, DiaYoke=100mm, Length=0mm, Skew=0deg, Slots=15, SlotType=3, Hs0=1mm, Hs01=0mm, Hs1=1.4910955mm, Hs2=9.67mm, Bs0=1mm, Bs1=6.1653063mm, Bs2=10.27615mm, Rs=0mm, FilletType=0, HalfSlot=0, SegAngle=15deg, LenRegion=0mm, InfoCore=0)
  Coil_0 [copper] = user_primitive(RMxprt/LapCoil, DiaGap=64mm, DiaYoke=100mm, Length=0mm, Skew=0deg, Slots=15, SlotType=3, Hs0=1mm, Hs1=1.4910955mm, Hs2=9.67mm, Bs0=1mm, Bs1=6.1653063mm, Bs2=10.27615mm, Rs=0mm, FilletType=0, Layers=2, CoilPitch=1, EndExt=0mm, SpanExt=0mm, BendAngle=0deg, SegAngle=10deg, LenRegion=0mm, InfoCoil=2)
  Coil_1..Coil_14 [copper] = Coil_0.duplicate_around_axis(axis=Z, angle=24deg, total=15)
  CoilRe_0 [copper] = user_primitive(RMxprt/LapCoil, DiaGap=64mm, DiaYoke=100mm, Length=0mm, Skew=0deg, Slots=15, SlotType=3, Hs0=1mm, Hs1=1.4910955mm, Hs2=9.67mm, Bs0=1mm, Bs1=6.1653063mm, Bs2=10.27615mm, Rs=0mm, FilletType=0, Layers=2, CoilPitch=1, EndExt=0mm, SpanExt=0mm, BendAngle=0deg, SegAngle=10deg, LenRegion=0mm, InfoCoil=3)
  CoilRe_0.rotate(axis=Z, angle=-24deg)
  CoilRe_1..CoilRe_14 [copper] = CoilRe_0.duplicate_around_axis(axis=Z, angle=24deg, total=15)
  Rotor [Cogent_2DSF0.950] = user_primitive(RMxprt/PMCore, DiaGap=62mm, DiaYoke=32mm, Length=0mm, Poles=14, PoleType=1, Embrace=0.889, ThickMag=4mm, WidthMag=0mm, Offset=0mm, Bridge=0mm, Rib=0mm, LenRegion=0mm, InfoCore=0)
  Mag_0 [Magnet_project2_2DSF1.000_N] = user_primitive(RMxprt/PMCore, DiaGap=62mm, DiaYoke=32mm, Length=0mm, Poles=14, PoleType=1, Embrace=0.889, ThickMag=4mm, WidthMag=0mm, Offset=0mm, Bridge=0mm, Rib=0mm, LenRegion=0mm, InfoCore=2)
  Mag_1 [Magnet_project2_2DSF1.000_S], Mag_2 [Magnet_project2_2DSF1.000_N], Mag_3 [Magnet_project2_2DSF1.000_S], Mag_4 [Magnet_project2_2DSF1.000_N], Mag_5 [Magnet_project2_2DSF1.000_S], Mag_6 [Magnet_project2_2DSF1.000_N], Mag_7 [Magnet_project2_2DSF1.000_S], Mag_8 [Magnet_project2_2DSF1.000_N], Mag_9 [Magnet_project2_2DSF1.000_S], Mag_10 [Magnet_project2_2DSF1.000_N], Mag_11 [Magnet_project2_2DSF1.000_S], Mag_12 [Magnet_project2_2DSF1.000_N], Mag_13 [Magnet_project2_2DSF1.000_S] = Mag_0.duplicate_around_axis(axis=Z, angle=25.714286deg, total=14)
  InnerRegion [vacuum] = user_primitive(RMxprt/PMCore, DiaGap=62mm, DiaYoke=32mm, Length=0mm, Poles=14, PoleType=1, Embrace=0.889, ThickMag=4mm, WidthMag=0mm, Offset=0mm, Bridge=0mm, Rib=0mm, LenRegion=0mm, InfoCore=100)
  Tool_1 = Tool.copy()
  Band.subtract(Tool_1)
  Tool_2 = Tool.copy()
  InnerRegion.subtract(Tool_2)
  Tool_3 = Tool.copy()
  Shaft.subtract(Tool_3)
  Tool_4 = Tool.copy()
  Stator.subtract(Tool_4)
  Tool_5 = Tool.copy()
  Coil_0.subtract(Tool_5)
  Tool_6 = Tool.copy()
  Coil_1.subtract(Tool_6)
  Tool_7 = Tool.copy()
  Coil_2.subtract(Tool_7)
  Tool_8 = Tool.copy()
  Coil_3.subtract(Tool_8)
  Tool_9 = Tool.copy()
  Coil_4.subtract(Tool_9)
  Tool_10 = Tool.copy()
  Coil_5.subtract(Tool_10)
  Tool_11 = Tool.copy()
  Coil_6.subtract(Tool_11)
  Tool_12 = Tool.copy()
  Coil_7.subtract(Tool_12)
  Tool_13 = Tool.copy()
  Coil_8.subtract(Tool_13)
  Tool_14 = Tool.copy()
  Coil_9.subtract(Tool_14)
  Tool_15 = Tool.copy()
  Coil_10.subtract(Tool_15)
  Tool_16 = Tool.copy()
  Coil_11.subtract(Tool_16)
  Tool_17 = Tool.copy()
  Coil_12.subtract(Tool_17)
  Tool_18 = Tool.copy()
  Coil_13.subtract(Tool_18)
  Tool_19 = Tool.copy()
  Coil_14.subtract(Tool_19)
  Tool_20 = Tool.copy()
  CoilRe_0.subtract(Tool_20)
  Tool_21 = Tool.copy()
  CoilRe_1.subtract(Tool_21)
  Tool_22 = Tool.copy()
  CoilRe_2.subtract(Tool_22)
  Tool_23 = Tool.copy()
  CoilRe_3.subtract(Tool_23)
  Tool_24 = Tool.copy()
  CoilRe_4.subtract(Tool_24)
  Tool_25 = Tool.copy()
  CoilRe_5.subtract(Tool_25)
  Tool_26 = Tool.copy()
  CoilRe_6.subtract(Tool_26)
  Tool_27 = Tool.copy()
  CoilRe_7.subtract(Tool_27)
  Tool_28 = Tool.copy()
  CoilRe_8.subtract(Tool_28)
  Tool_29 = Tool.copy()
  CoilRe_9.subtract(Tool_29)
  Tool_30 = Tool.copy()
  CoilRe_10.subtract(Tool_30)
  Tool_31 = Tool.copy()
  CoilRe_11.subtract(Tool_31)
  Tool_32 = Tool.copy()
  CoilRe_12.subtract(Tool_32)
  Tool_33 = Tool.copy()
  CoilRe_13.subtract(Tool_33)
  Tool_34 = Tool.copy()
  CoilRe_14.subtract(Tool_34)
  Tool_35 = Tool.copy()
  Rotor.subtract(Tool_35)
  Tool_36 = Tool.copy()
  Mag_0.subtract(Tool_36)
  Tool_37 = Tool.copy()
  Mag_1.subtract(Tool_37)
  Tool_38 = Tool.copy()
  Mag_2.subtract(Tool_38)
  Tool_39 = Tool.copy()
  Mag_3.subtract(Tool_39)
  Tool_40 = Tool.copy()
  Mag_4.subtract(Tool_40)
  Tool_41 = Tool.copy()
  Mag_5.subtract(Tool_41)
  Tool_42 = Tool.copy()
  Mag_6.subtract(Tool_42)
  Tool_43 = Tool.copy()
  Mag_7.subtract(Tool_43)
  Tool_44 = Tool.copy()
  Mag_8.subtract(Tool_44)
  Tool_45 = Tool.copy()
  Mag_9.subtract(Tool_45)
  Tool_46 = Tool.copy()
  Mag_10.subtract(Tool_46)
  Tool_47 = Tool.copy()
  Mag_11.subtract(Tool_47)
  Tool_48 = Tool.copy()
  Mag_12.subtract(Tool_48)
  Mag_13.subtract(Tool)
  middle_airgap [non-model] = polyline(z=0mm, xy in mm: (31.5, 0) (-31.5, 0.0027488936) (31.5, -0.0054977871), AngularArc from point 0 over 3 centre=(0mm, 0mm, 0mm) angle=359.99deg plane=XY)
  Band1 [vacuum] = user_primitive(RMxprt/Band, DiaGap=63.5mm, DiaYoke=32mm, Length=0mm, SegAngle=0deg, Fractions=1, HalfAxial=0, InfoCore=0)
  Tool1 = user_primitive(RMxprt/Band, DiaGap=63mm, DiaYoke=100mm, Length=0mm, SegAngle=0deg, Fractions=fractions, HalfAxial=0, InfoCore=1)
  Tool_49 = Tool1.copy()
  Band1.subtract(Tool_49)
  Tool1.delete()
  Band2 [vacuum] = user_primitive(RMxprt/Band, DiaGap=62.5mm, DiaYoke=32mm, Length=0mm, SegAngle=0deg, Fractions=1, HalfAxial=0, InfoCore=0)
  Tool2 = user_primitive(RMxprt/Band, DiaGap=63mm, DiaYoke=100mm, Length=0mm, SegAngle=0deg, Fractions=fractions, HalfAxial=0, InfoCore=1)
  Tool_50 = Tool2.copy()
  Band2.subtract(Tool_50)
  Tool2.delete()
  Band4 [vacuum] = user_primitive(RMxprt/Band, DiaGap=64mm, DiaYoke=32mm, Length=0mm, SegAngle=0deg, Fractions=1, HalfAxial=0, InfoCore=0)
  Tool4 = user_primitive(RMxprt/Band, DiaGap=63mm, DiaYoke=100mm, Length=0mm, SegAngle=0deg, Fractions=fractions, HalfAxial=0, InfoCore=1)
  Tool_52 = Tool4.copy()
  Band4.subtract(Tool_52)
  Tool4.delete()
  Band5 [vacuum] = user_primitive(RMxprt/Band, DiaGap=62.25mm, DiaYoke=32mm, Length=0mm, SegAngle=0deg, Fractions=1, HalfAxial=0, InfoCore=0)
  Tool5 = user_primitive(RMxprt/Band, DiaGap=63mm, DiaYoke=100mm, Length=0mm, SegAngle=0deg, Fractions=fractions, HalfAxial=0, InfoCore=1)
  Tool_53 = Tool5.copy()
  Band5.subtract(Tool_53)
  Tool5.delete()
  Band6 [vacuum] = user_primitive(RMxprt/Band, DiaGap=62.75mm, DiaYoke=32mm, Length=0mm, SegAngle=0deg, Fractions=1, HalfAxial=0, InfoCore=0)
  Tool6 = user_primitive(RMxprt/Band, DiaGap=63mm, DiaYoke=100mm, Length=0mm, SegAngle=0deg, Fractions=fractions, HalfAxial=0, InfoCore=1)
  Tool_54 = Tool6.copy()
  Band6.subtract(Tool_54)
  Tool6.delete()
  Band7 [vacuum] = user_primitive(RMxprt/Band, DiaGap=63.25mm, DiaYoke=32mm, Length=0mm, SegAngle=0deg, Fractions=1, HalfAxial=0, InfoCore=0)
  Tool7 = user_primitive(RMxprt/Band, DiaGap=63mm, DiaYoke=100mm, Length=0mm, SegAngle=0deg, Fractions=fractions, HalfAxial=0, InfoCore=1)
  Tool_55 = Tool7.copy()
  Band7.subtract(Tool_55)
  Tool7.delete()
  Band8 [vacuum] = user_primitive(RMxprt/Band, DiaGap=63.75mm, DiaYoke=32mm, Length=0mm, SegAngle=0deg, Fractions=1, HalfAxial=0, InfoCore=0)
  Tool8 = user_primitive(RMxprt/Band, DiaGap=63mm, DiaYoke=100mm, Length=0mm, SegAngle=0deg, Fractions=fractions, HalfAxial=0, InfoCore=1)
  Tool_56 = Tool8.copy()
  Band8.subtract(Tool_56)
  Tool8.delete()
motion:
  MotionSetup1: Band Move_Type=Rotate Coordinate_System=Global Axis=Z Is_Positive=true InitPos=12.8571deg Angular_Velocity=1500rpm Objects=Band
  Moving1: Moving Objects=[Shaft, Rotor, Mag_0..Mag_13, InnerRegion, Band2, Band5, Band6]
boundaries and excitations:
  VectorPotential1: Vector Potential Edges=OuterRegion.edge(at (0, 50, 0)) Value=0
  PhA_0: Coil Objects=Coil_0 Conductor_number=6 Winding=PhaseA PolarityType=Positive
  PhARe_0: Coil Objects=CoilRe_14 Conductor_number=6 Winding=PhaseA PolarityType=Negative
  PhARe_1: Coil Objects=Coil_1 Conductor_number=6 Winding=PhaseA PolarityType=Negative
  PhA_1: Coil Objects=CoilRe_0 Conductor_number=6 Winding=PhaseA PolarityType=Positive
  PhA_2: Coil Objects=Coil_2 Conductor_number=6 Winding=PhaseA PolarityType=Positive
  PhARe_2: Coil Objects=CoilRe_1 Conductor_number=6 Winding=PhaseA PolarityType=Negative
  PhB_3: Coil Objects=Coil_3 Conductor_number=6 Winding=PhaseB PolarityType=Positive
  PhBRe_3: Coil Objects=CoilRe_2 Conductor_number=6 Winding=PhaseB PolarityType=Negative
  PhBRe_4: Coil Objects=Coil_4 Conductor_number=6 Winding=PhaseB PolarityType=Negative
  PhB_4: Coil Objects=CoilRe_3 Conductor_number=6 Winding=PhaseB PolarityType=Positive
  PhB_5: Coil Objects=Coil_5 Conductor_number=6 Winding=PhaseB PolarityType=Positive
  PhBRe_5: Coil Objects=CoilRe_4 Conductor_number=6 Winding=PhaseB PolarityType=Negative
  PhBRe_6: Coil Objects=Coil_6 Conductor_number=6 Winding=PhaseB PolarityType=Negative
  PhB_6: Coil Objects=CoilRe_5 Conductor_number=6 Winding=PhaseB PolarityType=Positive
  PhB_7: Coil Objects=Coil_7 Conductor_number=6 Winding=PhaseB PolarityType=Positive
  PhBRe_7: Coil Objects=CoilRe_6 Conductor_number=6 Winding=PhaseB PolarityType=Negative
  PhC_8: Coil Objects=Coil_8 Conductor_number=6 Winding=PhaseC PolarityType=Positive
  PhCRe_8: Coil Objects=CoilRe_7 Conductor_number=6 Winding=PhaseC PolarityType=Negative
  PhCRe_9: Coil Objects=Coil_9 Conductor_number=6 Winding=PhaseC PolarityType=Negative
  PhC_9: Coil Objects=CoilRe_8 Conductor_number=6 Winding=PhaseC PolarityType=Positive
  PhC_10: Coil Objects=Coil_10 Conductor_number=6 Winding=PhaseC PolarityType=Positive
  PhCRe_10: Coil Objects=CoilRe_9 Conductor_number=6 Winding=PhaseC PolarityType=Negative
  PhCRe_11: Coil Objects=Coil_11 Conductor_number=6 Winding=PhaseC PolarityType=Negative
  PhC_11: Coil Objects=CoilRe_10 Conductor_number=6 Winding=PhaseC PolarityType=Positive
  PhC_12: Coil Objects=Coil_12 Conductor_number=6 Winding=PhaseC PolarityType=Positive
  PhCRe_12: Coil Objects=CoilRe_11 Conductor_number=6 Winding=PhaseC PolarityType=Negative
  PhA_13: Coil Objects=Coil_13 Conductor_number=6 Winding=PhaseA PolarityType=Positive
  PhARe_13: Coil Objects=CoilRe_12 Conductor_number=6 Winding=PhaseA PolarityType=Negative
  PhARe_14: Coil Objects=Coil_14 Conductor_number=6 Winding=PhaseA PolarityType=Negative
  PhA_14: Coil Objects=CoilRe_13 Conductor_number=6 Winding=PhaseA PolarityType=Positive
  PhaseA: Winding Group Type=Current IsSolid=false Current="I * sin(2 *pi * 175 * time)" ParallelBranchesNum=1
  PhaseB: Winding Group Type=Current IsSolid=false Current="I * sin(2 * PI * 175 * time - 2 * PI / 3)" ParallelBranchesNum=1
  PhaseC: Winding Group Type=Current IsSolid=false Current="I * sin(2 * PI * 175 * time - 4 * PI / 3)" ParallelBranchesNum=1
  external circuit: "* Design: MaxCir1\"
mesh:
  SurfApprox_Mag: SurfApproxBased Objects=[Mag_0..Mag_13] CurvedSurfaceApproxChoice=UseSlider SliderMeshSettings=9
  SurfApprox_Main: SurfApproxBased Objects=[Stator, Rotor, Band, OuterRegion, InnerRegion, Shaft] CurvedSurfaceApproxChoice=UseSlider SliderMeshSettings=9
  CylindricalGap1: CylindricalGap Objects=Band
  magnet: LengthBased RefineInside disabled Objects=[Mag_0, Mag_2, Mag_4, Mag_6, Mag_8, Mag_10, Mag_12, Mag_1, Mag_3, Mag_5, Mag_7, Mag_9, Mag_11, Mag_13] MaxLength=1mm
  coil: LengthBased RefineInside disabled Objects=[Coil_0..Coil_14, CoilRe_0..CoilRe_14] MaxLength=0.5mm
  stator: LengthBased RefineInside disabled Objects=Stator MaxLength=2mm
  rotor: LengthBased RefineInside disabled Objects=Rotor MaxLength=5mm
  Length1: LengthBased RefineInside Objects=Band8 MaxLength=0.05mm
  initial mesh: MeshMethod=AnsoftTAU
setups:
  Setup1: Transient NonlinearSolverResidual=1e-05 StopTime=2ms TimeStep=0.001ms OutputPerObjectCoreLoss SaveFieldsType="Every N Steps" N_Steps=1 Steps_From=0s Steps_To=0.04s NumberSolveSteps=1 RangeStart=0s RangeEnd=0.1s InitialTimeStep=0.002s MinTimeStep=0.001s MaxTimeStep=0.003s TimeStepErrTolerance=0.0001
output variables:
  pos = (Moving1.Position -12.8571 * PI/180) * 7 + PI
  cos0 = cos(pos)
  cos1 = cos(pos-2*PI/3)
  cos2 = cos(pos-4*PI/3)
  sin0 = sin(pos)
  sin1 = sin(pos-2*PI/3)
  sin2 = sin(pos-4*PI/3)
  Lad = L(PhaseA,PhaseA)*cos0 + L(PhaseA,PhaseB)*cos1 + L(PhaseA,PhaseC)*cos2
  Laq = L(PhaseA,PhaseA)*sin0 + L(PhaseA,PhaseB)*sin1 + L(PhaseA,PhaseC)*sin2
  Lbd = L(PhaseB,PhaseA)*cos0 + L(PhaseB,PhaseB)*cos1 + L(PhaseB,PhaseC)*cos2
  Lbq = L(PhaseB,PhaseA)*sin0 + L(PhaseB,PhaseB)*sin1 + L(PhaseB,PhaseC)*sin2
  Lcd = L(PhaseC,PhaseA)*cos0 + L(PhaseC,PhaseB)*cos1 + L(PhaseC,PhaseC)*cos2
  Lcq = L(PhaseC,PhaseA)*sin0 + L(PhaseC,PhaseB)*sin1 + L(PhaseC,PhaseC)*sin2
  L_d = (Lad*cos0 + Lbd*cos1 + Lcd*cos2) * 2/3
  L_q = (Laq*sin0 + Lbq*sin1 + Lcq*sin2) * 2/3
  Flux_d = (FluxLinkage(PhaseA)*cos0+FluxLinkage(PhaseB)*cos1+FluxLinkage(PhaseC)*cos2)*2/3
  Flux_q = (FluxLinkage(PhaseA)*sin0+FluxLinkage(PhaseB)*sin1+FluxLinkage(PhaseC)*sin2)*2/3
  I_d = (Current(PhaseA)*cos0 + Current(PhaseB)*cos1 + Current(PhaseC)*cos2)*2/3
  I_q = (Current(PhaseA)*sin0 + Current(PhaseB)*sin1 + Current(PhaseC)*sin2)*2/3
  Irms = sqrt(I_d^2+I_q^2)/sqrt(2)
  Pcu = 3*Irms^2*0
field calculator expressions:
  Br = B_Vector | Vector_Function(FuncValueX='0mm', FuncValueY='0mm', FuncValueZ='0mm') | ToCylindrical | ScalarX
field plots:
  Mag_B1: B over Stator, Rotor on Setup1 : Transient at Time=-1
  Flux_Lines1: A over Band, Shaft, OuterRegion, Stator, Coil_0..Coil_14, CoilRe_0..CoilRe_14, Rotor, Mag_0..Mag_13, InnerRegion, Band1, Band2, Band4..Band8 on Setup1 : Transient at Time=-1
  Mesh1: MeshPlots over Band, Shaft, OuterRegion, Stator, Coil_0..Coil_14, CoilRe_0..CoilRe_14, Rotor, Mag_0..Mag_13, InnerRegion, Band1, Band2, Band4..Band8 on Setup1 : Transient at Time=-1
reports:
  Air-gap Flux Density Distribution: Br vs Distance on Setup1 : Transient [Time=0s]; markers MX1 at x=0.014472671
  Flux Linkage: FluxLinkage(PhaseC), FluxLinkage(PhaseA), FluxLinkage(PhaseB) vs Time on Setup1 : Transient
  Winding Plot 1: InputCurrent(PhaseA), InputCurrent(PhaseB), InputCurrent(PhaseC) vs Time on Setup1 : Transient
  Cogging Torque: Moving1.Torque vs Moving1.Position on Setup1 : Transient
